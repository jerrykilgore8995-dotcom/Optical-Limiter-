* Manual optical limiter prototype -- vendor models required
* Run from manual/ with ngspice. No Auto mode.
* Behavioral elements explicitly mark unimplemented physical control blocks.
.include ../stage1/models/bjt.lib
.include ../stage1/models/opa134.lib
.include ../stage1/models/diodes.lib
.option reltol=1e-4 abstol=1e-11 method=gear
.param GDB=0 FREQ=1000 AMP=1 FF=1 RATIO=4 SOFT=1 SENS=15 HPF=0 ATT=10m REL=100m MAKEUP=0
VCC vp 0 24
VEE vn 0 -24
VOP op 0 15
VON on 0 -15
VIN src 0 SIN(0 {AMP} {FREQ})
EP ip 0 src 0 {0.5*exp(log(10)*GDB/20)}
EN im 0 src 0 {-0.5*exp(log(10)*GDB/20)}
.subckt leg in out vp vn params: CVAL=1u
CIN in b {CVAL}
RB b 0 47k
* Diode-connected complementary BJT bias string.
* 7.5k rail resistors provide ~3mA; 39R selected for target emitter current.
* Tune after authentic model DC operating point; Class A not yet verified.
RBIASP vp bn 7.5k
QBN bn bn bnp KSC1845
RBN bnp b 39
RBP b bpp 39
QBP bp bp bpp KSA992
RBIASN bp vn 7.5k
QN vp bn en KSC1845
QP vn bp ep KSA992
REN en out 47
REP ep out 47
.ends leg
* Locked 4.7uF input film pair, 1% total matching spread.
XP ip p vp vn leg CVAL=4.7235u
XM im m vp vn leg CVAL=4.6765u
* Reverse receiver polarity to cancel optical amplifier inversion.
R1 p neg 4.99k
R2 pre neg 4.99k
R3 m pos 4.99k
R4 pos 0 4.99k
XU1A pos neg op on pre OPA134
RIN pre sum 10k
RF gr sum 10k
CF gr sum 100p
XU1B 0 sum op on gr OPA134
* Provisional VTL5C1 conductance state, not validated against dynamic curves.
* Nominal resistance anchors 1mA=20k, 10mA=600, 40mA=200.
* Guard nonlinear functions at their point of evaluation, including Newton trials.
.func cs(x) {min(4,max(0,x))}
.func cg(x) {min(0.005,max(2e-8,x))}
Btarget target 0 V={cg(ternary_fcn(cs(V(sense))<0.1,2e-8+(5e-5-2e-8)*pow(cs(V(sense))/0.1,2),ternary_fcn(cs(V(sense))<1,5e-5*pow(max(0.1,cs(V(sense)))/0.1,1.52288),(1/600)*pow(max(1,cs(V(sense))),0.79248))))}
Ccell cell 0 1u IC=20n
* Explicit passive DC path and positive incremental conductance at all times.
* 5.63k recovery, 1k attack; supplemental current only during charging.
Rcell target cell 5.63k
Bcell target cell I={max(V(target,cell),0)*(1/1000-1/5630)}
Bldr gr sum I={V(gr,sum)*cg(V(cell))}
* Makeup stepped gain, effective feedback resistance; 0-ohm position approximated.
RG mgneg 0 2.2k
RMAKE make mgneg {max(1m,2200*(pow(10,MAKEUP/20)-1))}
XU2A gr mgneg op on make OPA134
XU2B make bufout op on bufout OPA134
* Locked AC-coupled active output; effective single-ended termination.
* Cold leg omitted: no external common-mode interference in plugin.
COUT bufout outcap 47u
ROBLEED outcap 0 20k
RO outcap out 47
RL out 0 10k
* Sidechain source selector.
Bselect sc 0 V={FF*V(pre)+(1-FF)*V(gr)}
XU3A sc scbuf op on scbuf OPA134
* HPF isolation retained; bypass selected without singular resistor values.
CH scbuf hp 100n
RH hp 0 {1/(6.283185307*max(HPF,10)*100n)}
VHPSEL hpsw 0 {ternary_fcn(HPF>0,1,0)}
BHPINV hpinv 0 V={1-V(hpsw)}
SHP hp hpselect hpsw 0 SWSEL
SBYP scbuf hpselect hpinv 0 SWSEL
.model SWSEL SW(Ron=0.01 Roff=1e12 Vt=0.5 Vh=0.05)
RHPBIAS hpselect 0 100Meg
XHPBUF hpselect hpsel op on hpsel OPA134
RHF hpsel hfneg 10k
RFB hfout hfneg 10k
CFB hfout hfneg 220p
XU3B 0 hfneg op on hfout OPA134
* Precision rectifier: half output = -max(input,0).
RHA hfout ha 4.99k
RHB half ha 4.99k
CHB half ha 22p
DHA oa ha D4148W
DHB half oa D4148W
XU4A 0 ha op on oa OPA134
RSA hfout sa 9.98k
RSB half sa 4.99k
RSF rect sa 9.98k
CSF rect sa 22p
XU4B 0 sa op on rect OPA134
* Average branch.
RA rect avg 10k
CA avg 0 100n
RAG an 0 10k
RAF avgo an 5.71k
CAF avgo an 22p
XAVG avg an op on avgo OPA134
* Peak branch: active hold with anti-saturation clamp.
RPKFB pkout pkneg 10k
CPKFB pkout pkneg 680p
XPK rect pkneg op on pkamp OPA134
DPC pkamp charge D4148W
RPC charge hold 100
DCL pkneg pkamp D4148W
CP hold 0 100n
RP hold 0 47k
XPKBUF hold pkout op on pkout OPA134
* Provisional ideal log / threshold / knee / ratio blocks.
* Absolute threshold reference 1V peak is provisional, not dBFS calibration.
Bdet det 0 V={RATIO<8 ? max(V(avgo),1e-9) : max(V(pkout),1e-9)}
* Physical 50k threshold pot and buffered reference; log conversion pending.
VREF ref 0 3
RPTOP ref pw {max(0.01,50000*(1-SENS/30))}
RPBOT pw 0 {max(0.01,50000*SENS/30)}
XPOT pw pbuf op on pbuf OPA134
BLOG logv 0 V={2*log10(max(1e-9,min(15,V(det))))}
* Summing amplifier and inverter provide 100mV/dB over-threshold voltage.
RLOG logv subneg 10k
RTH pbuf subneg 10k
RSUB subout subneg 10k
CSUB subout subneg 22p
XSUB 0 subneg op on subout OPA134
RINV subout invneg 10k
RIF ov100 invneg 10k
CIF ov100 invneg 22p
XINV 0 invneg op on ov100 OPA134
Bover over 0 V={10*max(-15,min(15,V(ov100)))}
* Feed-forward offers a 10 dB knee. Feedback uses the hard-knee command.
Bknee knee 0 V={SENS<=0 ? 0 : (FF>0.5 ? SOFT : 0) ? (V(over)<-5 ? 0 : V(over)>5 ? V(over) : pow(V(over)+5,2)/20) : max(V(over),0)}
* Physical ratio gain network, limited command still provisional.
BK100 k100 0 V={0.1*V(knee)}
RRIN k100 rrneg 10k
RRF rrout rrneg {10000*(FF ? 1-1/RATIO : RATIO-1)}
CRRF rrout rrneg 22p
XRATIO 0 rrneg op on rrout OPA134
Bcmd cmd 0 V={min(4,max(0,-V(rrout)))}
* Ideal precision steering surrogate, to replace with active diode network.
CT timing 0 1u
* Permanent physical release resistance plus directional attack correction.
RTIME cmd timing {REL/1u}
BT cmd timing I={max(V(cmd,timing),0)*(1u/ATT-1u/REL)}
XT timing tc op on tc OPA134
* Inverse static cell curve surrogate; 100mV/dB command: ln(10)/2 per volt.
* Physical shaping network pending.
Breq req 0 V={cg((exp(1.151292546497023*min(4,max(0,V(tc))))-1)/10000)}
Bdrive drive 0 V={min(3,max(0,ternary_fcn(cg(V(req))<5e-5,0.1*sqrt(max(1e-20,(cg(V(req))-2e-8)/(5e-5-2e-8))),ternary_fcn(cg(V(req))<1/600,0.1*pow(cg(V(req))/5e-5,1/1.52288),pow(cg(V(req))*600,1/0.79248)))))}
* Current driver; LED diode model is placeholder pending measured VTL LED model.
XDRV drive sense op on drv OPA134
RB drv base 100
QD ledc base sense Q2N2222A
RS sense 0 100
DLED op ledc VTL_LED
DREV ledc op D4148W
* Prevent reverse B-E stress when the zero-current loop reaches cutoff.
DBE sense base D4148W
RBE base sense 100k
.model VTL_LED D(IS=1e-16 N=2)
.op
.tran 0.5u 200m
.end
