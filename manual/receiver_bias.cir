* Receiver DC operating point test; run from manual directory.
.include ../stage1/models/bjt.lib
.include ../stage1/models/opa134.lib
VCC vp 0 24
VEE vn 0 -24
VOP op 0 15
VON on 0 -15
.param RB=7.5k REB=47
.subckt leg in out vp vn
CIN in b 1u
RIN b 0 47k
RBIASP vp bn {RB}
QBN bn bn bnp KSC1845
RBN bnp b {REB}
RBP b bpp {REB}
QBP bp bp bpp KSA992
RBIASN bp vn {RB}
VQN vp nc 0
VQP vn pc 0
QN nc bn en KSC1845
QP pc bp ep KSA992
REN en out 47
REP ep out 47
.ends leg
VIN ip 0 0
VIM im 0 0
XP ip p vp vn leg
XM im m vp vn leg
R1 p neg 4.99k
R2 pre neg 4.99k
R3 m pos 4.99k
R4 pos 0 4.99k
XU1A pos neg op on pre OPA134
RL pre 0 10k
.control
op
print v(p) v(m) v(pre) v(xp.bn) v(xp.bp) v(xp.en) v(xp.ep) i(v.xp.vqn) i(v.xp.vqp) i(v.xm.vqn) i(v.xm.vqp)
quit
.endc
.end
